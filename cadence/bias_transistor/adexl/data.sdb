ADE simulation setup
Run mode: Single Run, Sweeps and Corners
Tests:
  vsg_sweep: low_gm_ota/bias_transistor/schematic, simulator spectre
    Outputs: /MP0/S; OS("/MP0" "vdsat"); (OS("/MP0" "gm") / OS("/MP0" "id")); OS("/MP0" "vth")
  dc_op (off): low_gm_ota/bias_transistor/schematic, simulator spectre
  vsd_sweep (off): low_gm_ota/bias_transistor/schematic, simulator spectre
    Outputs: drain current
Global variables:
  W = 10u
  L = 1u
  vsg = 675.21m
  vsd = vsg
