ADE simulation setup
Run mode: Single Run, Sweeps and Corners
Tests:
  wdp_sweep (off): low_gm_ota/low_gm_ota_2/schematic, simulator spectre
    Outputs: /vcm; /nmos2; gm/id
  wn_sweep (off): low_gm_ota/low_gm_ota_2/schematic, simulator spectre
    Outputs: /nmos2; /vcm
  ln_sweep (off): low_gm_ota/low_gm_ota_2/schematic, simulator spectre
    Outputs: /vcm
  wp_sweep (off): low_gm_ota/low_gm_ota_2/schematic, simulator spectre
    Outputs: /vout; OS("/MP0" "gds")
  dc_op: low_gm_ota/low_gm_ota_2/schematic, simulator spectre
  vcm_sweep (off): low_gm_ota/low_gm_ota_2/schematic, simulator spectre
    Outputs: /vcm; (VDC("/vcm") - VDC("/vin+"))
  ac_gain (off): low_gm_ota/low_gm_ota_2/schematic, simulator spectre
    Outputs: /vout
  ac_rout (off): low_gm_ota/low_gm_ota_2/schematic, simulator spectre
    Outputs: /vout; (VF("/vout") / IF("/I7/MINUS"))
  ldp_sweep (off): low_gm_ota/low_gm_ota_2/schematic, simulator spectre
    Outputs: /vcm; OS("/MP0" "gds"); OS("/MP4" "gm"); OS("/MP4" "vth")
Global variables:
  Ln = 2.5u
  vcm = 0.3
  vd = 0
  Wdp = 200u
  Wn = 0.35u
  Wp = 60u
  Lp = 0.37u
  iac = 0
  Ldp = 0.647u
