ADE simulation setup
Run mode: Single Run, Sweeps and Corners
Tests:
  dc_op: low_gm_ota/low_gm_ota_w_stacked_cm/schematic, simulator spectre
  ln_sweep (off): low_gm_ota/low_gm_ota_w_stacked_cm/schematic, simulator spectre
    Outputs: /vcm; OS("/MP4" "vds"); OS("/MP4" "gm")
  ac_gain (off): low_gm_ota/low_gm_ota_w_stacked_cm/schematic, simulator spectre
    Outputs: /vout
  ac_rout (off): low_gm_ota/low_gm_ota_w_stacked_cm/schematic, simulator spectre
    Outputs: /vout
  lp_sweep (off): low_gm_ota/low_gm_ota_w_stacked_cm/schematic, simulator spectre
    Outputs: /vout
  wp_sweep (off): low_gm_ota/low_gm_ota_w_stacked_cm/schematic, simulator spectre
    Outputs: /vout
  ac_gain_over_vcm (off): low_gm_ota/low_gm_ota_w_stacked_cm/schematic, simulator spectre
    Outputs: /vout
Global variables:
  Ln = 1u
  vcm = 0.3
  vd = 0
  Wdp = 200u
  Wn = 0.35u
  Wp = 135.72u
  Lp = 0.35u
  iac = 0
  Ldp = 0.647u
